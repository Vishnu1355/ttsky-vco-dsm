* ring_pair reference netlist (docs/ring_interface.md): ring P <- vinp, ring N <- vinn
.subckt ring15 vin tap0 tap1 tap2 tap3 tap4 tap5 tap6 tap7 tap8 tap9 tap10 tap11 tap12 tap13 tap14 VDPWR VGND
XMNIN0 pb vin VGND VGND sky130_fd_pr__nfet_01v8 W=0.42 L=0.5
XMPD0 pb pb VDPWR VDPWR sky130_fd_pr__pfet_01v8 W=0.84 L=0.5
XMNIN1 pb vin VGND VGND sky130_fd_pr__nfet_01v8 W=0.42 L=0.5
XMPD1 pb pb VDPWR VDPWR sky130_fd_pr__pfet_01v8 W=0.84 L=0.5
XMNIN2 pb vin VGND VGND sky130_fd_pr__nfet_01v8 W=0.42 L=0.5
XMPD2 pb pb VDPWR VDPWR sky130_fd_pr__pfet_01v8 W=0.84 L=0.5
XMNIN3 pb vin VGND VGND sky130_fd_pr__nfet_01v8 W=0.42 L=0.5
XMPD3 pb pb VDPWR VDPWR sky130_fd_pr__pfet_01v8 W=0.84 L=0.5
XMNIN4 pb vin VGND VGND sky130_fd_pr__nfet_01v8 W=0.42 L=0.5
XMPD4 pb pb VDPWR VDPWR sky130_fd_pr__pfet_01v8 W=0.84 L=0.5
XMNIN5 pb vin VGND VGND sky130_fd_pr__nfet_01v8 W=0.42 L=0.5
XMPD5 pb pb VDPWR VDPWR sky130_fd_pr__pfet_01v8 W=0.84 L=0.5
XMNIN6 pb vin VGND VGND sky130_fd_pr__nfet_01v8 W=0.42 L=0.5
XMPD6 pb pb VDPWR VDPWR sky130_fd_pr__pfet_01v8 W=0.84 L=0.5
XMNIN7 pb vin VGND VGND sky130_fd_pr__nfet_01v8 W=0.42 L=0.5
XMPD7 pb pb VDPWR VDPWR sky130_fd_pr__pfet_01v8 W=0.84 L=0.5
XMPS0 sp0 pb VDPWR VDPWR sky130_fd_pr__pfet_01v8 W=0.84 L=0.5
XMP0 n0 n14 sp0 VDPWR sky130_fd_pr__pfet_01v8 W=0.84 L=0.15
XMN0 n0 n14 sn0 VGND sky130_fd_pr__nfet_01v8 W=0.42 L=0.15
XMNS0 sn0 vin VGND VGND sky130_fd_pr__nfet_01v8 W=0.42 L=0.5
XB1P0 b0 n0 VDPWR VDPWR sky130_fd_pr__pfet_01v8 W=0.84 L=0.15
XB1N0 b0 n0 VGND VGND sky130_fd_pr__nfet_01v8 W=0.42 L=0.15
XB2P0 tap0 b0 VDPWR VDPWR sky130_fd_pr__pfet_01v8 W=0.84 L=0.15
XB2N0 tap0 b0 VGND VGND sky130_fd_pr__nfet_01v8 W=0.42 L=0.15
XMPS1 sp1 pb VDPWR VDPWR sky130_fd_pr__pfet_01v8 W=0.84 L=0.5
XMP1 n1 n0 sp1 VDPWR sky130_fd_pr__pfet_01v8 W=0.84 L=0.15
XMN1 n1 n0 sn1 VGND sky130_fd_pr__nfet_01v8 W=0.42 L=0.15
XMNS1 sn1 vin VGND VGND sky130_fd_pr__nfet_01v8 W=0.42 L=0.5
XB1P1 b1 n1 VDPWR VDPWR sky130_fd_pr__pfet_01v8 W=0.84 L=0.15
XB1N1 b1 n1 VGND VGND sky130_fd_pr__nfet_01v8 W=0.42 L=0.15
XB2P1 tap1 b1 VDPWR VDPWR sky130_fd_pr__pfet_01v8 W=0.84 L=0.15
XB2N1 tap1 b1 VGND VGND sky130_fd_pr__nfet_01v8 W=0.42 L=0.15
XMPS2 sp2 pb VDPWR VDPWR sky130_fd_pr__pfet_01v8 W=0.84 L=0.5
XMP2 n2 n1 sp2 VDPWR sky130_fd_pr__pfet_01v8 W=0.84 L=0.15
XMN2 n2 n1 sn2 VGND sky130_fd_pr__nfet_01v8 W=0.42 L=0.15
XMNS2 sn2 vin VGND VGND sky130_fd_pr__nfet_01v8 W=0.42 L=0.5
XB1P2 b2 n2 VDPWR VDPWR sky130_fd_pr__pfet_01v8 W=0.84 L=0.15
XB1N2 b2 n2 VGND VGND sky130_fd_pr__nfet_01v8 W=0.42 L=0.15
XB2P2 tap2 b2 VDPWR VDPWR sky130_fd_pr__pfet_01v8 W=0.84 L=0.15
XB2N2 tap2 b2 VGND VGND sky130_fd_pr__nfet_01v8 W=0.42 L=0.15
XMPS3 sp3 pb VDPWR VDPWR sky130_fd_pr__pfet_01v8 W=0.84 L=0.5
XMP3 n3 n2 sp3 VDPWR sky130_fd_pr__pfet_01v8 W=0.84 L=0.15
XMN3 n3 n2 sn3 VGND sky130_fd_pr__nfet_01v8 W=0.42 L=0.15
XMNS3 sn3 vin VGND VGND sky130_fd_pr__nfet_01v8 W=0.42 L=0.5
XB1P3 b3 n3 VDPWR VDPWR sky130_fd_pr__pfet_01v8 W=0.84 L=0.15
XB1N3 b3 n3 VGND VGND sky130_fd_pr__nfet_01v8 W=0.42 L=0.15
XB2P3 tap3 b3 VDPWR VDPWR sky130_fd_pr__pfet_01v8 W=0.84 L=0.15
XB2N3 tap3 b3 VGND VGND sky130_fd_pr__nfet_01v8 W=0.42 L=0.15
XMPS4 sp4 pb VDPWR VDPWR sky130_fd_pr__pfet_01v8 W=0.84 L=0.5
XMP4 n4 n3 sp4 VDPWR sky130_fd_pr__pfet_01v8 W=0.84 L=0.15
XMN4 n4 n3 sn4 VGND sky130_fd_pr__nfet_01v8 W=0.42 L=0.15
XMNS4 sn4 vin VGND VGND sky130_fd_pr__nfet_01v8 W=0.42 L=0.5
XB1P4 b4 n4 VDPWR VDPWR sky130_fd_pr__pfet_01v8 W=0.84 L=0.15
XB1N4 b4 n4 VGND VGND sky130_fd_pr__nfet_01v8 W=0.42 L=0.15
XB2P4 tap4 b4 VDPWR VDPWR sky130_fd_pr__pfet_01v8 W=0.84 L=0.15
XB2N4 tap4 b4 VGND VGND sky130_fd_pr__nfet_01v8 W=0.42 L=0.15
XMPS5 sp5 pb VDPWR VDPWR sky130_fd_pr__pfet_01v8 W=0.84 L=0.5
XMP5 n5 n4 sp5 VDPWR sky130_fd_pr__pfet_01v8 W=0.84 L=0.15
XMN5 n5 n4 sn5 VGND sky130_fd_pr__nfet_01v8 W=0.42 L=0.15
XMNS5 sn5 vin VGND VGND sky130_fd_pr__nfet_01v8 W=0.42 L=0.5
XB1P5 b5 n5 VDPWR VDPWR sky130_fd_pr__pfet_01v8 W=0.84 L=0.15
XB1N5 b5 n5 VGND VGND sky130_fd_pr__nfet_01v8 W=0.42 L=0.15
XB2P5 tap5 b5 VDPWR VDPWR sky130_fd_pr__pfet_01v8 W=0.84 L=0.15
XB2N5 tap5 b5 VGND VGND sky130_fd_pr__nfet_01v8 W=0.42 L=0.15
XMPS6 sp6 pb VDPWR VDPWR sky130_fd_pr__pfet_01v8 W=0.84 L=0.5
XMP6 n6 n5 sp6 VDPWR sky130_fd_pr__pfet_01v8 W=0.84 L=0.15
XMN6 n6 n5 sn6 VGND sky130_fd_pr__nfet_01v8 W=0.42 L=0.15
XMNS6 sn6 vin VGND VGND sky130_fd_pr__nfet_01v8 W=0.42 L=0.5
XB1P6 b6 n6 VDPWR VDPWR sky130_fd_pr__pfet_01v8 W=0.84 L=0.15
XB1N6 b6 n6 VGND VGND sky130_fd_pr__nfet_01v8 W=0.42 L=0.15
XB2P6 tap6 b6 VDPWR VDPWR sky130_fd_pr__pfet_01v8 W=0.84 L=0.15
XB2N6 tap6 b6 VGND VGND sky130_fd_pr__nfet_01v8 W=0.42 L=0.15
XMPS7 sp7 pb VDPWR VDPWR sky130_fd_pr__pfet_01v8 W=0.84 L=0.5
XMP7 n7 n6 sp7 VDPWR sky130_fd_pr__pfet_01v8 W=0.84 L=0.15
XMN7 n7 n6 sn7 VGND sky130_fd_pr__nfet_01v8 W=0.42 L=0.15
XMNS7 sn7 vin VGND VGND sky130_fd_pr__nfet_01v8 W=0.42 L=0.5
XB1P7 b7 n7 VDPWR VDPWR sky130_fd_pr__pfet_01v8 W=0.84 L=0.15
XB1N7 b7 n7 VGND VGND sky130_fd_pr__nfet_01v8 W=0.42 L=0.15
XB2P7 tap7 b7 VDPWR VDPWR sky130_fd_pr__pfet_01v8 W=0.84 L=0.15
XB2N7 tap7 b7 VGND VGND sky130_fd_pr__nfet_01v8 W=0.42 L=0.15
XMPS8 sp8 pb VDPWR VDPWR sky130_fd_pr__pfet_01v8 W=0.84 L=0.5
XMP8 n8 n7 sp8 VDPWR sky130_fd_pr__pfet_01v8 W=0.84 L=0.15
XMN8 n8 n7 sn8 VGND sky130_fd_pr__nfet_01v8 W=0.42 L=0.15
XMNS8 sn8 vin VGND VGND sky130_fd_pr__nfet_01v8 W=0.42 L=0.5
XB1P8 b8 n8 VDPWR VDPWR sky130_fd_pr__pfet_01v8 W=0.84 L=0.15
XB1N8 b8 n8 VGND VGND sky130_fd_pr__nfet_01v8 W=0.42 L=0.15
XB2P8 tap8 b8 VDPWR VDPWR sky130_fd_pr__pfet_01v8 W=0.84 L=0.15
XB2N8 tap8 b8 VGND VGND sky130_fd_pr__nfet_01v8 W=0.42 L=0.15
XMPS9 sp9 pb VDPWR VDPWR sky130_fd_pr__pfet_01v8 W=0.84 L=0.5
XMP9 n9 n8 sp9 VDPWR sky130_fd_pr__pfet_01v8 W=0.84 L=0.15
XMN9 n9 n8 sn9 VGND sky130_fd_pr__nfet_01v8 W=0.42 L=0.15
XMNS9 sn9 vin VGND VGND sky130_fd_pr__nfet_01v8 W=0.42 L=0.5
XB1P9 b9 n9 VDPWR VDPWR sky130_fd_pr__pfet_01v8 W=0.84 L=0.15
XB1N9 b9 n9 VGND VGND sky130_fd_pr__nfet_01v8 W=0.42 L=0.15
XB2P9 tap9 b9 VDPWR VDPWR sky130_fd_pr__pfet_01v8 W=0.84 L=0.15
XB2N9 tap9 b9 VGND VGND sky130_fd_pr__nfet_01v8 W=0.42 L=0.15
XMPS10 sp10 pb VDPWR VDPWR sky130_fd_pr__pfet_01v8 W=0.84 L=0.5
XMP10 n10 n9 sp10 VDPWR sky130_fd_pr__pfet_01v8 W=0.84 L=0.15
XMN10 n10 n9 sn10 VGND sky130_fd_pr__nfet_01v8 W=0.42 L=0.15
XMNS10 sn10 vin VGND VGND sky130_fd_pr__nfet_01v8 W=0.42 L=0.5
XB1P10 b10 n10 VDPWR VDPWR sky130_fd_pr__pfet_01v8 W=0.84 L=0.15
XB1N10 b10 n10 VGND VGND sky130_fd_pr__nfet_01v8 W=0.42 L=0.15
XB2P10 tap10 b10 VDPWR VDPWR sky130_fd_pr__pfet_01v8 W=0.84 L=0.15
XB2N10 tap10 b10 VGND VGND sky130_fd_pr__nfet_01v8 W=0.42 L=0.15
XMPS11 sp11 pb VDPWR VDPWR sky130_fd_pr__pfet_01v8 W=0.84 L=0.5
XMP11 n11 n10 sp11 VDPWR sky130_fd_pr__pfet_01v8 W=0.84 L=0.15
XMN11 n11 n10 sn11 VGND sky130_fd_pr__nfet_01v8 W=0.42 L=0.15
XMNS11 sn11 vin VGND VGND sky130_fd_pr__nfet_01v8 W=0.42 L=0.5
XB1P11 b11 n11 VDPWR VDPWR sky130_fd_pr__pfet_01v8 W=0.84 L=0.15
XB1N11 b11 n11 VGND VGND sky130_fd_pr__nfet_01v8 W=0.42 L=0.15
XB2P11 tap11 b11 VDPWR VDPWR sky130_fd_pr__pfet_01v8 W=0.84 L=0.15
XB2N11 tap11 b11 VGND VGND sky130_fd_pr__nfet_01v8 W=0.42 L=0.15
XMPS12 sp12 pb VDPWR VDPWR sky130_fd_pr__pfet_01v8 W=0.84 L=0.5
XMP12 n12 n11 sp12 VDPWR sky130_fd_pr__pfet_01v8 W=0.84 L=0.15
XMN12 n12 n11 sn12 VGND sky130_fd_pr__nfet_01v8 W=0.42 L=0.15
XMNS12 sn12 vin VGND VGND sky130_fd_pr__nfet_01v8 W=0.42 L=0.5
XB1P12 b12 n12 VDPWR VDPWR sky130_fd_pr__pfet_01v8 W=0.84 L=0.15
XB1N12 b12 n12 VGND VGND sky130_fd_pr__nfet_01v8 W=0.42 L=0.15
XB2P12 tap12 b12 VDPWR VDPWR sky130_fd_pr__pfet_01v8 W=0.84 L=0.15
XB2N12 tap12 b12 VGND VGND sky130_fd_pr__nfet_01v8 W=0.42 L=0.15
XMPS13 sp13 pb VDPWR VDPWR sky130_fd_pr__pfet_01v8 W=0.84 L=0.5
XMP13 n13 n12 sp13 VDPWR sky130_fd_pr__pfet_01v8 W=0.84 L=0.15
XMN13 n13 n12 sn13 VGND sky130_fd_pr__nfet_01v8 W=0.42 L=0.15
XMNS13 sn13 vin VGND VGND sky130_fd_pr__nfet_01v8 W=0.42 L=0.5
XB1P13 b13 n13 VDPWR VDPWR sky130_fd_pr__pfet_01v8 W=0.84 L=0.15
XB1N13 b13 n13 VGND VGND sky130_fd_pr__nfet_01v8 W=0.42 L=0.15
XB2P13 tap13 b13 VDPWR VDPWR sky130_fd_pr__pfet_01v8 W=0.84 L=0.15
XB2N13 tap13 b13 VGND VGND sky130_fd_pr__nfet_01v8 W=0.42 L=0.15
XMPS14 sp14 pb VDPWR VDPWR sky130_fd_pr__pfet_01v8 W=0.84 L=0.5
XMP14 n14 n13 sp14 VDPWR sky130_fd_pr__pfet_01v8 W=0.84 L=0.15
XMN14 n14 n13 sn14 VGND sky130_fd_pr__nfet_01v8 W=0.42 L=0.15
XMNS14 sn14 vin VGND VGND sky130_fd_pr__nfet_01v8 W=0.42 L=0.5
XB1P14 b14 n14 VDPWR VDPWR sky130_fd_pr__pfet_01v8 W=0.84 L=0.15
XB1N14 b14 n14 VGND VGND sky130_fd_pr__nfet_01v8 W=0.42 L=0.15
XB2P14 tap14 b14 VDPWR VDPWR sky130_fd_pr__pfet_01v8 W=0.84 L=0.15
XB2N14 tap14 b14 VGND VGND sky130_fd_pr__nfet_01v8 W=0.42 L=0.15
.ends ring15
.subckt ring_pair vinp vinn tapP[0] tapP[1] tapP[2] tapP[3] tapP[4] tapP[5] tapP[6] tapP[7] tapP[8] tapP[9] tapP[10] tapP[11] tapP[12] tapP[13] tapP[14] tapN[0] tapN[1] tapN[2] tapN[3] tapN[4] tapN[5] tapN[6] tapN[7] tapN[8] tapN[9] tapN[10] tapN[11] tapN[12] tapN[13] tapN[14] VDPWR VGND
XRP vinp tapP[0] tapP[1] tapP[2] tapP[3] tapP[4] tapP[5] tapP[6] tapP[7] tapP[8] tapP[9] tapP[10] tapP[11] tapP[12] tapP[13] tapP[14] VDPWR VGND ring15
XRN vinn tapN[0] tapN[1] tapN[2] tapN[3] tapN[4] tapN[5] tapN[6] tapN[7] tapN[8] tapN[9] tapN[10] tapN[11] tapN[12] tapN[13] tapN[14] VDPWR VGND ring15
.ends ring_pair

* TinyTapeout wrapper: met3 power rails + pin extensions only (no devices)
.subckt ring_pair_tt vinp vinn tapP[0] tapP[1] tapP[2] tapP[3] tapP[4] tapP[5] tapP[6] tapP[7] tapP[8] tapP[9] tapP[10] tapP[11] tapP[12] tapP[13] tapP[14] tapN[0] tapN[1] tapN[2] tapN[3] tapN[4] tapN[5] tapN[6] tapN[7] tapN[8] tapN[9] tapN[10] tapN[11] tapN[12] tapN[13] tapN[14] VDPWR VGND
X0 vinp vinn tapP[0] tapP[1] tapP[2] tapP[3] tapP[4] tapP[5] tapP[6] tapP[7] tapP[8] tapP[9] tapP[10] tapP[11] tapP[12] tapP[13] tapP[14] tapN[0] tapN[1] tapN[2] tapN[3] tapN[4] tapN[5] tapN[6] tapN[7] tapN[8] tapN[9] tapN[10] tapN[11] tapN[12] tapN[13] tapN[14] VDPWR VGND ring_pair
.ends ring_pair_tt
